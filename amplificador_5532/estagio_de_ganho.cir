#!/usr/bin/ngspice

.include "NE5532.lib"

.title Estagio de Ganho

VI    IC1XNIN  0      dc    0  ac      1
VCC   VP       0      18
VEE   VN       0      -18

R3    IC1XNIN  0      47k

XIC1A IC1XNIN IC1AINV VP   VN IC1AOUT NE5532
R4    IC1AINV 0       910R
R5    IC1AOUT IC1AINV 2k2
C3    IC1AOUT IC1AINV 33p
R8    IC1AOUT IC2ANIN 10R

XIC1B IC1XNIN IC1BINV VP   VN IC1BOUT NE5532
R6    IC1BINV 0       910R
R7    IC1BOUT IC1BINV 2k2
C4    IC1BOUT IC1BINV 33p
R9    IC1BOUT IC2ANIN 10R

XIC2A IC2ANIN IC2AINV VP   VN IC2AOUT NE5532
R10   IC2AINV 0       2k2
R11   IC2AOUT IC2AINV 2k2
C6    IC2AOUT IC2AINV 33p

XIC2B IC2AOUT IC2BOUT VP   VN IC2BOUT NE5532
R12   IC2BOUT IC3BINV 1k

XIC3B 0       IC3BINV VP   VN IC3BOUT NE5532
C8    IC3BOUT IC3BINV 33p
R13   K3      IC3BINV 2k
R14   IC3BOUT K3      47R

.end

.ac dec 100 100k 100Meg

.control

run
plot vdb(K3)
wrdata estagio_de_ganho.data vdb(K3)

.endc
