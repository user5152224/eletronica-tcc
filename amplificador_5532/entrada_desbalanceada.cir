#!/usr/bin/ngspice

.title Entrada desbalanceada

Vin  K1 0 dc 0 ac 1

V+15 +15V 0   15
V-15 0   -15V 15

R1 K1    UNBAL 47
R2 UNBAL 0     220k
C1 UNBAL 0     100p

.ac dec 100 1Meg 100Meg
.end

.control

run
gnuplot gp vdb(UNBAL) ylabel dB
quit

.endc
